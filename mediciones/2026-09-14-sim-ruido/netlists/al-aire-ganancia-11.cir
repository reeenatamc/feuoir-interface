* Input stage, split supply, gain 11: noise at the PCM1808 input, open input
.include opamp_tl072h.cir
.include input_stage.cir
.include guitar.cir

Vbat_pos bpos 0 DC 9.0
Rbat_pos bpos vpos 2.0
Vbat_neg 0 bneg DC 9.0
Rbat_neg bneg vneg 2.0
* Nothing connected to C1. Rleak only gives that node a DC path, and Vref is the source
* the noise analysis needs as its input.
Vref ref 0 DC 0 AC 1
Rleak ref in 1G
Xstage in adc vpos vneg input_stage_split params: rpot=10000
Rload adc 0 60000

.control
set noaskquit
set filetype=ascii
noise v(adc) vref dec 50 1 1meg
setplot noise1
write noise.raw onoise_spectrum inoise_spectrum
quit
.endc

.end
