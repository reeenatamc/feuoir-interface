* Guitar alone, loaded with 1meg Ohm, 600pF cable
.include guitar.cir

Vemf emf 0 DC 0 AC 1
Xguitar emf out guitar params: ccable=600p
Rload out 0 1meg

.control
set noaskquit
set filetype=ascii
ac dec 100 1 1meg
write ac.raw v(out)
quit
.endc

.end
