* Input stage, single supply, gain 3: frequency response at the PCM1808 input
.include opamp_tl072.cir
.include input_stage.cir

Vbat bpos 0 DC 9.0
Rbat bpos vpos 2.0
Vin in 0 DC 0 AC 1
Xstage in adc vpos input_stage_single params: rpot=2000
Rload adc 0 60000

.control
set noaskquit
set filetype=ascii
ac dec 50 1 1meg
write ac.raw v(adc)
quit
.endc

.end
