* Model check: input noise of TI's TL07XH_TL08XH model, as a follower with +-9 V.
* With rsource at 1 mOhm the output noise is the op-amp's own voltage noise. With 1 MOhm it also carries the
* input current noise times rsource, plus the resistor's thermal noise (spice/characterize.py separates them).
* Needs ngbehavior=ps: the library uses PSpice syntax.

.include tl07xh_tl08xh.lib
.param rsource=1m

Vpos vcc 0 DC 9
Vneg vee 0 DC -9
Vin src 0 DC 0 AC 1
Rsource src in {rsource}
XU1 in out vcc vee out TL07XH_TL08XH

.control
set noaskquit
set filetype=ascii
noise v(out) vin dec 50 10 100k
setplot noise1
write noise_spectrum.raw onoise_spectrum
quit
.endc

.end
